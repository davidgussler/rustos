addrmap examp_regs {
  name = "RDL Example";
  desc = "Example register description.";

  default accesswidth = 32;
  default regwidth = 32;

  common_regfile common; 

  reg {
    name = "Control Register";
    desc = "Overall control register.";
    default sw = rw;
    default hw = r;
    field {} ctl0[0:0] = 1;
    field {} ctl1[1:1] = 1;
  } control;

  reg {
    name = "Status Register";
    desc = "Overall status register.";
    default sw = r;
    default hw = w;
    field {
      name = "Status 0";
    } sts0[0:0];
    field {
      name = "Status 1";
    } sts1[1:1];
  } status;

  reg {
    desc = "SW and HW can write, we flag needed to trigger write from hw. Also include outputs for swacc (rd / wr) and swmod (wr)";
    default sw = rw;
    default hw = rw;
    default we;
    default swacc;
    default swmod;
    field {} data[32] = 0x0000000B;
  } hwrw;

  reg {
    desc = "Write pulse register. Just a write pulse";
    default sw = w;
    default hw = r;
    default swmod;
    field {} data = 0;
  } wr_pulse [2];

  reg {
    desc = "Counter register. Just a simple up counter";
    default sw = r;
    default counter; // is a counter that infers an increment control hardware input signal
    field {} cnt[15:0] = 0;
  } cntr [2];

};